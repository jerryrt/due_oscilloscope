Stage A - nominal vendor models, 27 C, ideal Due rail and DAC sources
.include stage_a.net
.control
set filetype=ascii
set wr_vecnames
set wr_singlescale
op
print v(vref3v0) v(vref1v5) v(a2) v(a0) v(a1) i(V3V3)
wrdata op.dat v(vref3v0) v(vref1v5) v(a2) v(a0) v(a1)
dc VDAC0 0.5 2.5 0.1
let error = v(a0)-v(dac0)
wrdata dc.dat v(dac0) v(a0) error
ac dec 100 1k 100meg
let gain_db = db(v(a0))
let buffer_db = db(v(buffer))
meas ac f3db when gain_db=-3
wrdata ac.dat gain_db buffer_db
tran 2n 40u
wrdata tran.dat v(dac0) v(a0) v(a1) v(vref3v0) v(vref1v5)
alterparam AREF_C=200n
reset
tran 5n 40u
wrdata aref_load.dat v(vref3v0) v(vref1v5)
quit
.endc
.end
