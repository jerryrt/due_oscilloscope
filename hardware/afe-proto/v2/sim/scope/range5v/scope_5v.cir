* AFE version 2 scope channels, range 5v (version 1's +-5 V values, range5v.md): two unity followers on one TPH2502 dual, +3.3 V only (nominal values).
* Generated by run.py (section netlist); every value and its LCSC code is in design.md.  Run from this directory:
*   ngspice -b scope_v2.cir
* Per channel (suffix a = CH1, b = CH2):
*   R1a 470k C23178 + R1b 300k C23024 (IN -> N)       C1 12p C0G C38523 across R1 (Cr1: 0.1 pF stray, not a part)
*   R2a 470k C23178 + R2b 330k C23137 (N -> GND)       Cn 30p C0G C1658, N -> GND (Cnp: 3.5 pF stray, not a part)
*   R3a 330k C23137 + R3b 0R C21189 (N -> REF3030E output)
*   Rnp 470 C23179 (N -> +IN)   Cpx 10p C0G C1634 (+IN -> GND)   Riso 22 C23345 (OUT -> ADC pin)   Dp: BAV99 C2500 (GND / pin / +3.3 V_A)
* TPH2502 C118223 is one dual: XUa is half A, XUb half B.  The vendor macro is the single-amplifier TPH2501 and
* is read from whatif/tph2502/models/ (local, uncommitted, hashed in models/VENDOR_MODEL.sha256).
* Parasitics (Cw BNC+trace 4 pF, Cr1, Cnp, Cfb, Cpin), the source Rs and the ADC input are *(assumption)*: report.md.
* scope_v2
.include TPH2501_ngspice.mdl
.model DESD D(IS=1e-15 N=1 RS=5)
.model DBAV99 D(IS=7.8e-9 N=2.35 RS=1.5 CJO=1.5p M=0.4 VJ=0.7 BV=70 IBV=2.5u)
.options abstol=1e-13 itl1=4000 itl4=500 reltol=1e-4 method=gear
* supply: ideal 3.3 V behind 0.1 ohm + 10 nH, 100 nF + 1 uF at the amplifier
Vcc vcc0 0 dc 3.3
Rvc vcc0 vcx 0.1
Lvc vcx vccl 1e-08
Cdc1 vccl cd1 100n
Rdc1 cd1 0 0.02
Cdc2 vccl cd2 1u
Rdc2 cd2 0 0.02
* REF3030E: 3.0 V behind 0.05 ohm, 1 uF + 100 nF at its output (the ladder's top tap also loads it)
Vr vr0 0 dc 3.0
Rvr vr0 ref 0.05
Cr1u ref cr1 1u
Rcr1 cr1 0 0.02
Cr100 ref cr2 100n
Rcr2 cr2 0 0.02
Vsa asrc 0 dc 0 ac 1
Vsb bsrc 0 dc 0
* channel a
Rsa asrc ain 50
Cwa ain 0 4e-12
R1aa ain am1 470000
R1ba am1 an 300000
C1a ain an 1.2e-11
Cr1a ain an 1e-13
R2aa an am2 470000
R2ba am2 0 330000
R3aa an am3 330000
R3ba am3 ref 0
Cna an 0 3e-11
Cnpa an 0 3.5e-12
Rnpa an anp 470
Cpxa anp 0 1e-11
XUa anp afb vccl 0 aout TPH2501_simplify
Vfba aout afb dc 0
Cfba afb 0 1e-12
Risoa aout apin 22
Cpina apin 0 2e-12
Dpaa 0 apin DBAV99
Dpba apin vccl DBAV99
* channel b
Rsb bsrc bin 50
Cwb bin 0 4e-12
R1ab bin bm1 470000
R1bb bm1 bn 300000
C1b bin bn 1.2e-11
Cr1b bin bn 1e-13
R2ab bn bm2 470000
R2bb bm2 0 330000
R3ab bn bm3 330000
R3bb bm3 ref 0
Cnb bn 0 3e-11
Cnpb bn 0 3.5e-12
Rnpb bn bnp 470
Cpxb bnp 0 1e-11
XUb bnp bfb vccl 0 bout TPH2501_simplify
Vfbb bout bfb dc 0
Cfbb bfb 0 1e-12
Risob bout bpin 22
Cpinb bpin 0 2e-12
Dpab 0 bpin DBAV99
Dpbb bpin vccl DBAV99

.control
op
print v(apin) v(bpin)
ac dec 20 1k 1g
.endc
.end
