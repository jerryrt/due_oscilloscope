* v2 AWG output stage, TPH2502 dual: both halves paralleled as one gain stage (V2-2: no spare half); generated by core.build
* TPH2502 (3PEAK dual), the single swappable model file of v2/sim/awg.
*
* Every netlist instantiates  X<name> inp inn vp vn out TPH2502   and nothing else of the model.  To swap in another
* model (a vendor TPH2502 model, a behavioural one), replace the body of this file; the pin order is the one used here:
*   inp  non-inverting input    inn  inverting input    vp  V+    vn  V-    out  output
*
* What is under it now (2026-11-12): 3PEAK's own TPH2501 PSpice model ("TPH2501_simplify", the single-channel member of the
* TPH2501/2/3/4 family: one datasheet covers all four), as converted for ngspice by the whatif/tph2502 work
* (models/TPH2501_ngspice.mdl: only the tc1 on IRP removed).  VENDOR FILE, local only, never committed (MC-6):
*   whatif/tph2502/models/TPH2501_ngspice.mdl   sha256 256eeb242fe2d960625eb2c8b8d94d71a3e982730a617f01eb8cfcf90322fae1
*   from models/tph2501/Spice_Model_TPH2501/TPH2501.mdl  sha256 fc600102aee23b7a929fa8e7779b3200ff1f14d05ed5794cd07a010d6604ce98
* Vendor pin order of TPH2501_simplify: 1 IN+, 2 IN-, 3 V+, 4 V-, 5 OUT.
*
* What the model is NOT (measured against the datasheet by whatif/tph2502/smoke/ and by this directory's run.py 'model' case):
*   - input noise 9.3 nV/rtHz flat against the datasheet's 6.5 at 1 MHz (+43 %): noise results carry both figures;
*   - open-loop output resistance 38 ohm against 21 (smoke/zo.cir);
*   - one op-amp per instance: no dual crosstalk (datasheet -100 dB at 5 MHz), no shared supply pin, no thermal shutdown;
*   - no swing-versus-current curve exists in the datasheet (v2/parts.md): the model's own output stage decides the
*     50 ohm top end, which is why that row is marked (check).
* The include path below is written by run.py relative to the netlist directory; this file is a template and is
* read by run.py, which substitutes ../../../../whatif/tph2502/models/TPH2501_ngspice.mdl.
.include ../../../../whatif/tph2502/models/TPH2501_ngspice.mdl
.subckt TPH2502 inp inn vp vn out
X1 inp inn vp vn out TPH2501_simplify
.ends TPH2502

* ---- output-stage saturation, DERIVED, for the headroom and short-circuit cases only --------------------------------
* The vendor macromodel's output stage reaches within 40 mV of a rail at any load current and draws no supply current for
* it (measured by run.py 'model': 8.0 mA from V+ at 0 and at 30 mA of load), so it cannot say what the swing is at 30 mA.
* The datasheet has no swing-versus-current curve (v2/parts.md); its text (p. 7, "Output Stage") says "a continuous output
* current of +-100 mA and still approximately 2.7 V of output swing on a 5 V supply", i.e. 1.15 V lost per rail at 100 mA:
* a saturation resistance of 11.5 ohm per rail if the loss is linear in current (an assumption, check: no curve).
* TPH2502_SAT is the same pin order with that drop applied behind the macromodel: out = oi - max(0, oi - (V+ - rsat I))
* + max(0, (V- + rsat |I|) - oi), I the current leaving oi.  The supply-pin current is added by run.py (IQ + I out).
.subckt TPH2502_SAT inp inn vp vn out params: rsat=11.5
X1 inp inn vp vn oi TPH2501_simplify
Vs oi o2 0
Bd o2 out V = max(0, v(oi) - (v(vp) - {rsat}*max(i(Vs), 0))) - max(0, (v(vn) + {rsat}*max(-i(Vs), 0)) - v(oi))
.ends TPH2502_SAT

Vvp vpx 0 DC 3.3
Vvn vnx 0 DC -2.073
Rvp vpx vcc 0.2
Rvn vnx vee 0.2
Cdp vcc 0 1e-07
Cdn vee 0 1e-07
Vdac dacs 0 DC 1.6745
Rdacs dacs dac 1m
Rbin dac bin 2400.0
Rbpl bin 0 27000.0
XA bin fb vcc vee oa TPH2502
XB bin fb vcc vee ob TPH2502
Rba oa vo 1.0
Rbb ob vo 1.0
Rf vo fb 470.0
Rg2 fb vref 510.0
Cfb fb 0 2e-12
Vrf vrfs 0 DC 3.0
Rzr vrfs vref 0.05
Czr vref 0 1.1e-06
Cf vo fb 1e-11
Cpv bin 0 1.5e-12
Ro vo bnc 50.0
Cout bnc 0 3.3e-10
Rl bnc 0 1Meg
Cl bnc 0 15p

.op
.end
